//! Runs every day on its real input, with timings: `cheby run aoc::all`.
//! `cheby run -- new N`, `remove N` and `sync` rewrite this file.

import aoc::kit

fn main() -> Result<Nil, kit::Error> {
  kit::run_all([])
}
