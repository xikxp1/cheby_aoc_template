//! Searches over puzzle states: breadth-first search, Dijkstra's shortest
//! paths, counting the paths of a graph without cycles, finding where a
//! repeated step starts to cycle, and disjoint sets (union-find).
//!
//! A state is any value that `==` and hashing work on, such as a position
//! `(x, y)` or a record of a position and a direction. `dijkstra` also
//! orders states, so its states satisfy `Compare`, as tuples of `Int`s do.

import std::heap
import std::list
import std::map
import std::ops::{Compare}
import std::option

/// The number of steps from `start` to every state it reaches, where
/// `next` gives the states one step from a state.
pub fn bfs<S>(start: S, next: fn(S) -> List<S>) -> map::Map<S, Int> {
  fn level(frontier: List<S>, depth: Int, seen: map::Map<S, Int>) -> map::Map<S, Int> {
    case frontier {
      [] => seen
      _ => {
        let (fresh, known) = expand(frontier, next, depth + 1, seen)
        level(fresh, depth + 1, known)
      }
    }
  }
  level([start], 0, map::from_list([(start, 0)]))
}

/// The number of steps from `start` to the nearest state for which
/// `is_goal` holds, or `None` when no such state is reachable.
pub fn bfs_to<S>(start: S, next: fn(S) -> List<S>, is_goal: fn(S) -> Bool) -> Option<Int> {
  fn level(frontier: List<S>, depth: Int, seen: map::Map<S, Int>) -> Option<Int> {
    case frontier, list::any(frontier, is_goal) {
      [], _ => None
      _, True => Some(depth)
      _, False => {
        let (fresh, known) = expand(frontier, next, depth + 1, seen)
        level(fresh, depth + 1, known)
      }
    }
  }
  level([start], 0, map::from_list([(start, 0)]))
}

/// The states one step from `frontier` that `seen` does not hold yet, and
/// `seen` with them at `depth`.
fn expand<S>(
  frontier: List<S>,
  next: fn(S) -> List<S>,
  depth: Int,
  seen: map::Map<S, Int>,
) -> (List<S>, map::Map<S, Int>) {
  list::fold(frontier, ([], seen), fn((found, visited), state) {
    list::fold(next(state), (found, visited), fn((more, marked), neighbour) {
      case map::has_key(marked, neighbour) {
        True => (more, marked)
        False => (list::push(more, neighbour), map::insert(marked, neighbour, depth))
      }
    })
  })
}

/// The cost of the cheapest path from `start` to a state for which
/// `is_goal` holds, or `None` when no such state is reachable. `next`
/// gives each state one step away with the step's cost, which must not be
/// negative.
pub fn dijkstra<S: Compare>(
  start: S,
  next: fn(S) -> List<(S, Int)>,
  is_goal: fn(S) -> Bool,
) -> Option<Int> {
  fn step(queue: heap::Heap<(Int, S)>, best: map::Map<S, Int>) -> Option<Int> {
    case heap::pop(queue) {
      None => None
      Some(((cost, state), rest)) => case map::get(best, state) {
        Some(known) when known < cost => step(rest, best)
        _ => case is_goal(state) {
          True => Some(cost)
          False => {
            let (queued, improved) = relax(state, cost, next, rest, best)
            step(queued, improved)
          }
        }
      }
    }
  }
  step(heap::push(heap::new_min(), (0, start)), map::from_list([(start, 0)]))
}

/// The cost of the cheapest path from `start` to every state it reaches.
pub fn dijkstra_all<S: Compare>(start: S, next: fn(S) -> List<(S, Int)>) -> map::Map<S, Int> {
  fn step(queue: heap::Heap<(Int, S)>, best: map::Map<S, Int>) -> map::Map<S, Int> {
    case heap::pop(queue) {
      None => best
      Some(((cost, state), rest)) => case map::get(best, state) {
        Some(known) when known < cost => step(rest, best)
        _ => {
          let (queued, improved) = relax(state, cost, next, rest, best)
          step(queued, improved)
        }
      }
    }
  }
  step(heap::push(heap::new_min(), (0, start)), map::from_list([(start, 0)]))
}

/// Queues each neighbour of `state` that its cost reaches more cheaply
/// than any path found so far.
fn relax<S: Compare>(
  state: S,
  cost: Int,
  next: fn(S) -> List<(S, Int)>,
  queue: heap::Heap<(Int, S)>,
  best: map::Map<S, Int>,
) -> (heap::Heap<(Int, S)>, map::Map<S, Int>) {
  list::fold(next(state), (queue, best), fn((queued, known), (neighbour, weight)) {
    let total = cost + weight
    case map::get(known, neighbour) {
      Some(old) when old <= total => (queued, known)
      _ => (heap::push(queued, (total, neighbour)), map::insert(known, neighbour, total))
    }
  })
}

/// Where repeating `step` from `start` starts to cycle: the index of the
/// first state that comes back, and the length of the cycle. State 0 is
/// `start`. It does not stop when no state ever repeats.
pub fn find_cycle<S>(start: S, step: fn(S) -> S) -> (Int, Int) {
  let (_, first, length) = walk_to_cycle(start, step)
  (first, length)
}

/// The state after `n` steps from `start`, found through the cycle of
/// `find_cycle` instead of taking every step, for puzzles that ask about a
/// billion steps.
pub fn state_after<S>(start: S, step: fn(S) -> S, n: Int) -> S {
  let (states, first, length) = walk_to_cycle(start, step)
  let index = case n < first {
    True => n
    False => first + (n - first) % length
  }
  option::expect(list::get(states, index), "the index lies inside the walk")
}

/// The states from `start` up to the first that repeats, the index of the
/// earlier copy of that state, and the length of the cycle.
fn walk_to_cycle<S>(start: S, step: fn(S) -> S) -> (List<S>, Int, Int) {
  fn walk(state: S, index: Int, states: List<S>, seen: map::Map<S, Int>) -> (List<S>, Int, Int) {
    case map::get(seen, state) {
      Some(first) => (states, first, index - first)
      None => walk(
        step(state),
        index + 1,
        list::push(states, state),
        map::insert(seen, state, index),
      )
    }
  }
  walk(start, 0, [], map::new())
}

/// The number of paths from `start` to `goal`, where `next` gives the
/// states one step from a state. The graph must have no cycles. Each
/// state's count is computed once and kept in a map, so a graph with
/// trillions of paths takes as long as one with few.
pub fn count_paths<S>(start: S, goal: S, next: fn(S) -> List<S>) -> Int {
  fn count(state: S, known: map::Map<S, Int>) -> (Int, map::Map<S, Int>) {
    guard state != goal else {
      (1, known)
    }
    case map::get(known, state) {
      Some(paths) => (paths, known)
      None => {
        let (total, filled) = list::fold(next(state), (0, known), fn((sum, seen), to) {
          let (paths, after) = count(to, seen)
          (sum + paths, after)
        })
        (total, map::insert(filled, state, total))
      }
    }
  }
  let (paths, _) = count(start, map::new())
  paths
}

// Disjoint sets

/// Keys split into disjoint groups, the structure also called union-find.
/// A key that `union` never joined to another is a group of its own. It is
/// persistent: `union` returns new sets and leaves the old ones as they
/// were.
pub type Sets<K> {
  /// Each key's parent. A root, the key that names its group, is its own
  /// parent.
  parent: map::Map<K, K>,
  /// The size of each root's group. A root missing here is alone.
  size: map::Map<K, Int>,
}

/// Sets in which each of `keys` is a group of its own. `groups` and
/// `sizes` count these keys, and the keys that `union` adds later.
pub fn new_sets<K>(keys: List<K>) -> Sets<K> {
  let parent = list::fold(keys, map::new(), fn(found, key) { map::insert(found, key, key) })
  Sets { parent, size: map::new() }
}

/// The root of `key`'s group: two keys are in the same group when their
/// roots are equal. `find` cannot shorten the path it walks, because that
/// would change the sets. `union` joins the smaller group under the larger
/// and shortens the paths it walks, so a path stays short.
pub fn find<K>(sets: Sets<K>, key: K) -> K {
  case map::get(sets.parent, key) {
    Some(up) when up != key => find(sets, up)
    _ => key
  }
}

/// Whether `a` and `b` are in the same group.
pub fn same<K>(sets: Sets<K>, a: K, b: K) -> Bool {
  find(sets, a) == find(sets, b)
}

/// The sets with the groups of `a` and `b` joined into one. Keys that the
/// sets do not hold yet are added.
pub fn union<K>(sets: Sets<K>, a: K, b: K) -> Sets<K> {
  let root_a = find(sets, a)
  let root_b = find(sets, b)
  let size_a = group_size(sets, root_a)
  let size_b = group_size(sets, root_b)
  let (root, other) = case size_a >= size_b {
    True => (root_a, root_b)
    False => (root_b, root_a)
  }
  let parent = sets.parent
    |> point_to(_, a, root)
    |> point_to(_, b, root)
  case root == other {
    True => Sets { ..sets, parent }
    False => {
      let size = sets.size
        |> map::remove(_, other)
        |> map::insert(_, root, size_a + size_b)
      Sets { parent, size }
    }
  }
}

/// The size of the group whose root is `root`.
fn group_size<K>(sets: Sets<K>, root: K) -> Int {
  map::get_or(sets.size, root, 1)
}

/// `parent` with every key on the path from `key` to its root pointing
/// at `root` instead.
fn point_to<K>(parent: map::Map<K, K>, key: K, root: K) -> map::Map<K, K> {
  let up = map::get_or(parent, key, key)
  let pointed = map::insert(parent, key, root)
  case up == key {
    True => pointed
    False => point_to(pointed, up, root)
  }
}

/// The groups, each a list of its keys. The order of the groups and of the
/// keys in a group changes between runs, as a map's order does, so sort
/// them before printing.
pub fn groups<K>(sets: Sets<K>) -> List<List<K>> {
  sets.parent
  |> map::fold(_, map::new(), fn(found, key, _) {
    map::upsert(found, find(sets, key), fn(old) { list::push(option::unwrap_or(old, []), key) })
  })
  |> map::values
}

/// The size of every group, largest first.
pub fn sizes<K>(sets: Sets<K>) -> List<Int> {
  sets
  |> groups
  |> list::map(_, list::length)
  |> list::sort
  |> list::reverse
}

/// A small graph for the tests: each number steps to the next two, and a
/// step to `n + 2` costs 3.
fn steps(n: Int) -> List<(Int, Int)> {
  [(n + 1, 2), (n + 2, 3)]
}

test "bfs counts steps to every reachable state" {
  let distances = bfs(0, fn(n) {
    case n < 4 {
      True => [n + 1, n + 2]
      False => []
    }
  })
  assert map::get(distances, 0) == Some(0)
  assert map::get(distances, 2) == Some(1)
  assert map::get(distances, 5) == Some(3)
  assert map::size(distances) == 6
}

test "bfs_to stops at the nearest goal" {
  assert bfs_to(0, fn(n) { [n + 1, n * 2] }, fn(n) { n == 10 }) == Some(5)
  assert bfs_to(0, fn(_) { [] }, fn(n) { n == 1 }) == None
}

test "dijkstra finds the cheapest path" {
  assert dijkstra(0, steps, fn(n) { n == 4 }) == Some(6)
  assert dijkstra(0, steps, fn(n) { n == 3 }) == Some(5)
  assert dijkstra(0, fn(_) { [] }, fn(n) { n == 3 }) == None
  let costs = dijkstra_all(0, fn(n) {
    case n < 3 {
      True => steps(n)
      False => []
    }
  })
  assert map::get(costs, 4) == Some(6)
}

test "a cycle is found and skipped over" {
  // 0, 1, 2, 3, 4, 2, 3, 4, …: the cycle starts at index 2 and has length 3.
  let step = fn(n) {
    case n {
      4 => 2
      _ => n + 1
    }
  }
  assert find_cycle(0, step) == (2, 3)
  assert state_after(0, step, 1) == 1
  assert state_after(0, step, 5) == 2
  assert state_after(0, step, 1_000_000_000) == 4
}

test "count_paths counts every path of a graph without cycles" {
  // From n, step to n + 1 and n + 2: the ways to climb 10 stairs.
  let climb = fn(n) { list::filter([n + 1, n + 2], fn(to) { to <= 10 }) }
  assert count_paths(0, 10, climb) == 89
  assert count_paths(3, 3, climb) == 1
  assert count_paths(0, 11, climb) == 0
  let long = fn(n) { list::filter([n + 1, n + 2], fn(to) { to <= 90 }) }
  assert count_paths(0, 90, long) == 4_660_046_610_375_530_309
}

test "union joins groups and find names them" {
  let sets = new_sets([1, 2, 3, 4, 5, 6])
    |> union(_, 1, 2)
    |> union(_, 3, 4)
    |> union(_, 2, 4)
  assert same(sets, 1, 3)
  assert !same(sets, 1, 5)
  assert find(sets, 4) == find(sets, 1)
  assert sizes(sets) == [4, 1, 1]
  let sorted = sets
    |> groups
    |> list::map(_, list::sort)
    |> list::sort
  assert sorted == [[1, 2, 3, 4], [5], [6]]
  // A union of keys that are already together changes no group.
  assert sizes(union(sets, 4, 1)) == [4, 1, 1]
  // Keys that the sets do not hold yet are added.
  let more = union(sets, 7, 8)
  assert sizes(more) == [4, 2, 1, 1]
  assert same(more, 8, 7)
  assert !same(sets, 7, 8)
}

test "union works on any key" {
  let cells = new_sets([])
    |> union(_, (0, 0), (0, 1))
    |> union(_, (5, 5), (0, 1))
  assert same(cells, (5, 5), (0, 0))
  assert sizes(cells) == [3]
  let names = union(new_sets(["a", "b", "c"]), "c", "a")
  assert sizes(names) == [2, 1]
}
